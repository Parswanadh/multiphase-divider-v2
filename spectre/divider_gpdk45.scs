// 8-phase divide-by-2 divider (Kuo et al., IEEE LMWT 2025) on Cadence GPDK045 (gpdk045_v_6_0)
// Standalone Spectre netlist. Run in the VM:  spectre divider_gpdk45.scs -format nutascii -raw out.raw
//
// Model file / device names below were read from the real gpdk045_v_6_0 package:
//   models/spectre/gpdk045.scs  provides corner sections  tt ff ss fs sf
//   the 1.0 V standard-Vt NMOS is the subcircuit  g45n1svt (d g s b)  params l w nf multi
//   (it is what the Virtuoso library cell nmos1v netlists to)
// Sizes and bias are STARTING VALUES; `mult` scales every device in parallel (model param multi) so the
// unit sizes stay inside the valid model bins (W=240n L=45n bin 30, W=480n L=90n bin 23).
simulator lang=spectre

include "/home/buet/pdk/gpdk045_v_6_0/models/spectre/gpdk045.scs" section=tt

parameters vdd=1.0 fin=1G tck=1/fin tr=20p cl=10f rl=8k vb=0.8 mult=1
simulatorOptions options temp=27 tnom=27

VDD (vdd 0)   vsource dc=vdd
VB  (nbias 0) vsource dc=vb
VCK  (ck  0) vsource type=pulse val0=0 val1=vdd delay=0       rise=tr fall=tr width=tck/2-tr period=tck
VCKB (ckb 0) vsource type=pulse val0=0 val1=vdd delay=tck/2   rise=tr fall=tr width=tck/2-tr period=tck

subckt DLATCH (D Db CK CKb Q Qb VDD VSS NBIAS)
  R1 (VDD Q)  resistor r=rl
  R2 (VDD Qb) resistor r=rl
  M1 (Q  D  xs   VSS) g45n1svt w=240n l=45n multi=mult
  M2 (Qb Db xs   VSS) g45n1svt w=240n l=45n multi=mult
  M5 (xs CK tail VSS) g45n1svt w=240n l=45n multi=mult
  M3 (Q  Qb xh   VSS) g45n1svt w=240n l=45n multi=mult
  M4 (Qb Q  xh   VSS) g45n1svt w=240n l=45n multi=mult
  M6 (xh CKb tail VSS) g45n1svt w=240n l=45n multi=mult
  M7 (tail NBIAS VSS VSS) g45n1svt w=480n l=90n multi=mult
ends DLATCH

// interconnect: Q1b->D2, Q2->D3, Q3b->D4, Q4->D1b
XD1 (Q4b Q4  ck  ckb Q1 Q1b vdd 0 nbias) DLATCH
XD2 (Q1b Q1  ckb ck  Q2 Q2b vdd 0 nbias) DLATCH
XD3 (Q2  Q2b ckb ck  Q3 Q3b vdd 0 nbias) DLATCH
XD4 (Q3b Q3  ck  ckb Q4 Q4b vdd 0 nbias) DLATCH

CL1  (Q1  0) capacitor c=cl
CL1b (Q1b 0) capacitor c=cl
CL2  (Q2  0) capacitor c=cl
CL2b (Q2b 0) capacitor c=cl
CL3  (Q3  0) capacitor c=cl
CL3b (Q3b 0) capacitor c=cl
CL4  (Q4  0) capacitor c=cl
CL4b (Q4b 0) capacitor c=cl

// start-up: without initial conditions the symmetric state may never resolve
ic Q1=1.0 Q1b=0 Q2=1.0 Q2b=0 Q3=0 Q3b=1.0 Q4=0 Q4b=1.0

opinfo info what=oppoint where=file file="oppoint.txt"
tran tran stop=40n ic=node errpreset=conservative maxstep=5p
save Q1 Q1b Q2 Q2b Q3 Q3b Q4 Q4b ck VDD:p XD1.tail XD2.tail
