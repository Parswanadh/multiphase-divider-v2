simulator('spectre)
design("divider_lib" "tb_divider" "schematic")
resultsDir("/home/buet/gpdk_run/ocean_tb")
modelFile('("/home/buet/pdk/gpdk045_v_6_0/models/spectre/gpdk045.scs" "tt"))
analysis('tran ?stop "40n" ?errpreset "conservative" ?maxstep "5p")
temp(27)
ic("/Q1" "1.0" "/Q1b" "0" "/Q2" "1.0" "/Q2b" "0" "/Q3" "0" "/Q3b" "1.0" "/Q4" "0" "/Q4b" "1.0")
save('all)
printf("OC run: %L\n" run())
selectResult('tran)
printf("OC t1=%L t2=%L t3=%L\n" cross(v("/Q1") 0.86 6 "rising") cross(v("/Q1") 0.86 7 "rising") cross(v("/Q1") 0.86 8 "rising"))
printf("OC ck1=%L ck2=%L\n" cross(v("/CK") 0.5 10 "rising") cross(v("/CK") 0.5 11 "rising"))
printf("OC Q1 min=%L max=%L\n" ymin(clip(v("/Q1") 20n 40n)) ymax(clip(v("/Q1") 20n 40n)))
printf("OC Iavg=%L\n" average(clip(i("/VDD/PLUS") 20n 40n)))
exit()
