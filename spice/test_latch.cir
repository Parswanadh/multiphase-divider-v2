.include spice/models/cmos180.mod
.global nbias
Vdd Vdd 0 1.8
Vbias nbias 0 1.2
Vck CK 0 PULSE(0 1.8 0 50p 50p 307p 714p)
Vckb CKb 0 PULSE(0 1.8 357p 50p 50p 307p 714p)
Vd D 0 1.8
Vdb Db 0 0

.subckt DLATCH D Db CK CKb Q Qb VDD
R1 VDD Q 1.5k
R2 VDD Qb 1.5k
M1 Q D xs xs nmos W=0.9u L=0.18u
M2 Qb Db xs xs nmos W=0.9u L=0.18u
M5 xs CK tail tail nmos W=0.9u L=0.18u
M3 Q Qb xh xh nmos W=0.9u L=0.18u
M4 Qb Q xh xh nmos W=0.9u L=0.18u
M6 xh CKb tail tail nmos W=0.9u L=0.18u
M7 tail nbias 0 0 nmos W=1.8u L=0.36u
.ends DLATCH

XD D Db CK CKb Q Qb Vdd DLATCH
.nodeset V(Q)=1.8 V(Qb)=0 V(xs)=0.5 V(xh)=0.5 V(tail)=0.2
.tran 5p 20n
.control
run
print v(q) > results/qlatch.txt
print v(xd.xs) > results/xs.txt
print v(xd.tail) > results/tail.txt
print v(ck) > results/ck2.txt
quit
.endc
.end
