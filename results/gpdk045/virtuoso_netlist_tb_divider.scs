// Design: divider_lib/tb_divider
simulator lang=spectre
global 0
include "/home/buet/pdk/gpdk045_v_6_0/models/spectre/gpdk045.scs" section=tt

// divider_lib/DLATCH/schematic
subckt DLATCH CK CKb D Db NBIAS Q Qb VDD VSS
    R2 (VDD Qb) resistor r=3K
    R1 (VDD Q) resistor r=3K
    M7 (tail NBIAS VSS VSS) g45n1svt w=(480n) l=90n nf=1 m=(4)
    M6 (xh CKb tail VSS) g45n1svt w=(240n) l=45n nf=1 m=(4)
    M4 (Qb Q xh VSS) g45n1svt w=(240n) l=45n nf=1 m=(4)
    M3 (Q Qb xh VSS) g45n1svt w=(240n) l=45n nf=1 m=(4)
    M5 (xs CK tail VSS) g45n1svt w=(240n) l=45n nf=1 m=(4)
    M2 (Qb Db xs VSS) g45n1svt w=(240n) l=45n nf=1 m=(4)
    M1 (Q D xs VSS) g45n1svt w=(240n) l=45n nf=1 m=(4)
ends DLATCH

// divider_lib/divider_core/schematic
subckt divider_core CK CKb NBIAS Q1 Q1b Q2 Q2b Q3 Q3b Q4 Q4b VDD VSS
    XD4 (CK CKb Q3b Q3 NBIAS Q4 Q4b VDD VSS) DLATCH
    XD3 (CKb CK Q2 Q2b NBIAS Q3 Q3b VDD VSS) DLATCH
    XD2 (CKb CK Q1b Q1 NBIAS Q2 Q2b VDD VSS) DLATCH
    XD1 (CK CKb Q4b Q4 NBIAS Q1 Q1b VDD VSS) DLATCH
ends divider_core

// divider_lib/tb_divider/schematic
VB (NBIAS 0) vsource dc=800.0m type=dc
VDD (VDD 0) vsource dc=1 type=dc
VCKB (CKb 0) vsource type=pulse val0=0 val1=1 period=1n delay=500p rise=20p fall=20p width=480.0p
VCK (CK 0) vsource type=pulse val0=0 val1=1 period=1n delay=0 rise=20p fall=20p width=480.0p
XCORE (CK CKb NBIAS Q1 Q1b Q2 Q2b Q3 Q3b Q4 Q4b VDD 0) divider_core
CL4b (Q4b 0) capacitor c=10f
CL4 (Q4 0) capacitor c=10f
CL3b (Q3b 0) capacitor c=10f
CL3 (Q3 0) capacitor c=10f
CL2b (Q2b 0) capacitor c=10f
CL2 (Q2 0) capacitor c=10f
CL1b (Q1b 0) capacitor c=10f
CL1 (Q1 0) capacitor c=10f
ic Q4b=1.0 Q4=0 Q3b=1.0 Q3=0 Q2b=0 Q2=1.0 Q1b=0 Q1=1.0
simulatorOptions options temp=27
tran tran stop=40n errpreset=conservative maxstep=5p
saveOptions options currents=all
